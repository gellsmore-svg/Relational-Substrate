* AMS HF AC 05 - Bottleneck in otherwise good route
* Tests whether improving the surrounding route concentrates stress at the bottleneck.

.param RGOOD=10
.param RBOT=1k
.param CBOT=10p
Vin in 0 AC 1
Rgood1 in nb1 {RGOOD}
Rbottle nb1 nb2 {RBOT}
Cbottle nb1 nb2 {CBOT}
Rgood2 nb2 out {RGOOD}
Rload out 0 10k

.control
set filetype=ascii
ac dec 40 10 100Meg
wrdata 05_bottleneck_route.csv frequency v(out) i(Vin) v(nb1) v(nb2)
quit
.endc

.end
