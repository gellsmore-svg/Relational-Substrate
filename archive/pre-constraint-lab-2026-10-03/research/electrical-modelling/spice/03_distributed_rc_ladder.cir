* AMS HF AC 03 - Distributed RC ladder
* Same route interpreted as distributed storage/release.

.param RSEG=100
.param CSEG=10p
Vin in 0 AC 1
R1 in n1 {RSEG}
C1 n1 0 {CSEG}
R2 n1 n2 {RSEG}
C2 n2 0 {CSEG}
R3 n2 n3 {RSEG}
C3 n3 0 {CSEG}
R4 n3 n4 {RSEG}
C4 n4 0 {CSEG}
R5 n4 n5 {RSEG}
C5 n5 0 {CSEG}
R6 n5 n6 {RSEG}
C6 n6 0 {CSEG}
R7 n6 n7 {RSEG}
C7 n7 0 {CSEG}
R8 n7 n8 {RSEG}
C8 n8 0 {CSEG}
R9 n8 n9 {RSEG}
C9 n9 0 {CSEG}
R10 n9 out {RSEG}
C10 out 0 {CSEG}

.control
set filetype=ascii
ac dec 40 10 100Meg
wrdata 03_distributed_rc_ladder.csv frequency v(out) i(Vin) v(n5)
quit
.endc

.end
