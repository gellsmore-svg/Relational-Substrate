* AMS HF AC 02 - Resistor with parasitic capacitance
* Shows storage/lock-up effect against a nominal route resistance.

.param RVAL=1k
.param CPAR=100p
Vin in 0 AC 1
R1 in out {RVAL}
Cpar out 0 {CPAR}

.control
set filetype=ascii
ac dec 40 10 100Meg
wrdata 02_resistor_parasitic_cap.csv frequency v(out) i(Vin)
quit
.endc

.end
