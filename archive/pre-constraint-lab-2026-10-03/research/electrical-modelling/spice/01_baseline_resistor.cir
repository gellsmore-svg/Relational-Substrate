* AMS HF AC 01 - Baseline pure resistor
* T2 equivalent-circuit model only.

.param RVAL=1k
Vin in 0 AC 1
R1 in 0 {RVAL}

.control
set filetype=ascii
ac dec 20 10 100Meg
wrdata 01_baseline_resistor.csv frequency v(in) i(Vin)
quit
.endc

.end
