* AMS HF AC 06 - Transmission line with termination mismatch
* Uses an ideal lossless transmission line as a starter reflection model.

.param Z0=50
.param TD=10n
.param RLOAD=200
Vin src 0 AC 1
Rs src in {Z0}
T1 in 0 out 0 Z0={Z0} TD={TD}
Rload out 0 {RLOAD}

.control
set filetype=ascii
ac dec 80 100k 1Gig
wrdata 06_transmission_line_mismatch.csv frequency v(out) v(in) i(Vin)
quit
.endc

.end
